* comparator-kickback -- GENERATED by sim/tools/mk_klt_request.py, do not edit
* dut=pair+tail-cgr-0250-1000 (extracted) sha256=f029c8898f26238b
* source-sha256 f029c8898f26238b2f3b3cebc6dc5047b2382964745e75e616ed24bf444c4cfb sources/dut/variant.cir
* source-sha256 e6d70b7b55728d39466a057eb5f880e1bedb3f4ba1f8532a58c655ce4b7f1f1b sources/dut-binding.json
* source-sha256 7522a3fff330a0dcd6d0554bc232c4b16e21b949ab98ac4fffac658331bb99fb sources/testbench/tb.json
* source-sha256 f42495917522fa2c726d29ad6ef053284482489c93da3b9bc2236678fea4e090 sources/testbench/tb_kickback.spice
* source-sha256 3a1bd8f03483f1028effeb71342f46e468aa007a4f4902cbc0c0ec25c5bf9632 sources/testbench/tb_vosprobe.spice
.param vdd_nom=3.3
.param vdd_val=2.97
.param temp_c=27.0
.param dut_ib=1e-05
.param dut_vcm=1.65
.param dut_vos=-0.0033379719355899964
.include "design.ngspice"
.options reltol=1e-4
.options vntol=1e-9
.options abstol=1e-15
.options chgtol=1e-16
.include "sources/dut/variant.cir"
.include "sources/testbench/tb_kickback.spice"
