* comparator-kickback -- GENERATED by sim/tools/mk_klt_request.py, do not edit
* dut=tail-x1.5-cgr-0250-0500 (extracted) sha256=8fe3b53e4e5838e8
* source-sha256 8fe3b53e4e5838e8bdc94178c6165163e4a6c9d521fde220c5559b530a3c12b1 sources/dut/variant.cir
* source-sha256 e4470d926e617b26fe536089ed1c5dd42ba97c5fd8ee519c8becd48f8712e2c8 sources/dut-binding.json
* source-sha256 7522a3fff330a0dcd6d0554bc232c4b16e21b949ab98ac4fffac658331bb99fb sources/testbench/tb.json
* source-sha256 f42495917522fa2c726d29ad6ef053284482489c93da3b9bc2236678fea4e090 sources/testbench/tb_kickback.spice
* source-sha256 3a1bd8f03483f1028effeb71342f46e468aa007a4f4902cbc0c0ec25c5bf9632 sources/testbench/tb_vosprobe.spice
.param vdd_nom=3.3
.param vdd_val=2.97
.param temp_c=27.0
.param dut_ib=1e-05
.param dut_vcm=1.65
.param dut_vos=-0.003308078193979991
.include "design.ngspice"
.options reltol=1e-4
.options vntol=1e-9
.options abstol=1e-15
.options chgtol=1e-16
.include "sources/dut/variant.cir"
.include "sources/testbench/tb_kickback.spice"
