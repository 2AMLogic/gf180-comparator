* klt sim -- generated corner deck, do not edit
.lib /opt/pdk/gf180mcuD/libs.tech/ngspice/sm141064.ngspice ss
.lib /opt/pdk/gf180mcuD/libs.tech/ngspice/sm141064.ngspice res_ss
.lib /opt/pdk/gf180mcuD/libs.tech/ngspice/sm141064.ngspice bjt_ss
.lib /opt/pdk/gf180mcuD/libs.tech/ngspice/sm141064.ngspice diode_ss
.lib /opt/pdk/gf180mcuD/libs.tech/ngspice/sm141064.ngspice moscap_ss
.lib /opt/pdk/gf180mcuD/libs.tech/ngspice/sm141064.ngspice mimcap_ss
.include /var/tmp/eda-job-klt-sim-b5076ef327cd/inputs/netlist.cir
.temp 125.0
.meas tran t_flip when v(dn)=0.5 rise=1 td=8u
.control
save all
tran 100n 80u 0 100n
quit
.endc
.end
