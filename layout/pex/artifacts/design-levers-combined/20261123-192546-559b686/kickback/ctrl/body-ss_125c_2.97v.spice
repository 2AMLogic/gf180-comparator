* comparator-kickback -- GENERATED by sim/tools/mk_klt_request.py, do not edit
* dut=ctrl (extracted) sha256=a7ca3c00ea4db8a2
* source-sha256 a7ca3c00ea4db8a2b00cad69f2edc2d9320738499049cfa9c7faec517b7b5f45 sources/dut/variant.cir
* source-sha256 d38699275b2210adf1e6991531cc1843fcdbd8c1a27ca288b988fb41bd5ac889 sources/dut-binding.json
* source-sha256 7522a3fff330a0dcd6d0554bc232c4b16e21b949ab98ac4fffac658331bb99fb sources/testbench/tb.json
* source-sha256 f42495917522fa2c726d29ad6ef053284482489c93da3b9bc2236678fea4e090 sources/testbench/tb_kickback.spice
* source-sha256 3a1bd8f03483f1028effeb71342f46e468aa007a4f4902cbc0c0ec25c5bf9632 sources/testbench/tb_vosprobe.spice
.param vdd_nom=3.3
.param vdd_val=2.97
.param temp_c=27.0
.param dut_ib=1e-05
.param dut_vcm=1.65
.param dut_vos=-0.005166640204629994
.include "design.ngspice"
.options reltol=1e-4
.options vntol=1e-9
.options abstol=1e-15
.options chgtol=1e-16
.include "sources/dut/variant.cir"
.include "sources/testbench/tb_kickback.spice"
