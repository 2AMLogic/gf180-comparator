* preamp-noise-pvt leg=schematic -- GENERATED by layout/pex/preamp_noise_pvt.py (issue #209), do not edit
* source-sha256 0df618e73b1f0736aac33c786eac58e5a7381f55b3a4e41dc4eb56d9a8ad0d8a sources/schematic/comparator.spice
.param vdd_nom=3.3
.param vdd_val=3.3
.param temp_c=27.0
.param dut_ib=1e-05
.param dut_vcm=1.65
.include "design.ngspice"
.include "sources/schematic/comparator.spice"
vsup vdd 0 dc {vdd_val}
vcm  cm 0 dc {dut_vcm}
vd   vd 0 dc 0 ac 1
Eap  ap cm vd 0 0.5
Ean  an cm vd 0 -0.5
ib   vdd ibn dc {dut_ib}
* the WHOLE comparator, held in reset (clk low)
vclk clk 0 dc 0
Xdut ap an clk ibn dout doutb vdd 0 comparator_dut
.control
set num_threads=1
.endc
