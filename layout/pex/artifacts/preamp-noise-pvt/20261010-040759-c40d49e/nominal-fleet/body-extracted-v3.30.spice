* preamp-noise-pvt leg=extracted -- GENERATED by layout/pex/preamp_noise_pvt.py (issue #209), do not edit
* source-sha256 a7ca3c00ea4db8a2b00cad69f2edc2d9320738499049cfa9c7faec517b7b5f45 sources/extracted/comparator.dut-layout.cir
.param vdd_nom=3.3
.param vdd_val=3.3
.param temp_c=27.0
.param dut_ib=1e-05
.param dut_vcm=1.65
.include "design.ngspice"
.include "sources/extracted/comparator.dut-layout.cir"
vsup vdd 0 dc {vdd_val}
vcm  cm 0 dc {dut_vcm}
vd   vd 0 dc 0 ac 1
Eap  ap cm vd 0 0.5
Ean  an cm vd 0 -0.5
ib   vdd ibn dc {dut_ib}
* the WHOLE comparator, held in reset (clk low)
vclk clk 0 dc 0
Xdut ap an clk ibn dout doutb vdd 0 comparator_dut
.control
set num_threads=1
.endc
