* schematic_bench_croute -- GENERATED by layout/pex/preamp_noise_probe.py (issue #202), do not edit
.param vdd_nom=3.3
.param vdd_val=3.3
.param temp_c=27.0
.param dut_ib=1e-05
.param dut_vcm=1.65
.include "/home/ubuntu/.volare/gf180mcuD/libs.tech/ngspice/design.ngspice"
.lib "/home/ubuntu/.volare/gf180mcuD/libs.tech/ngspice/sm141064.ngspice" typical
.lib "/home/ubuntu/.volare/gf180mcuD/libs.tech/ngspice/sm141064.ngspice" res_typical
.lib "/home/ubuntu/.volare/gf180mcuD/libs.tech/ngspice/sm141064.ngspice" bjt_typical
.lib "/home/ubuntu/.volare/gf180mcuD/libs.tech/ngspice/sm141064.ngspice" diode_typical
.lib "/home/ubuntu/.volare/gf180mcuD/libs.tech/ngspice/sm141064.ngspice" moscap_typical
.lib "/home/ubuntu/.volare/gf180mcuD/libs.tech/ngspice/sm141064.ngspice" mimcap_typical
.temp 27.0
.include "/home/ubuntu/GitHub/gf180-comparator/.loom/worktrees/issue-202/design/comparator.spice"

vsup vdd 0 dc {vdd_val}
vcm  cm 0 dc {dut_vcm}
vd   vd 0 dc 0 ac 1
Eap  ap cm vd 0 0.5
Ean  an cm vd 0 -0.5
ib   vdd ibn dc {dut_ib}
* the WHOLE comparator, held in reset (clk low)
vclk clk 0 dc 0
Xdut ap an clk ibn dout doutb vdd 0 comparator_dut
Cwp xdut.aop 0 10f
Cwn xdut.aon 0 10f

.control
set numdgt=10
set noaskquit
op
let dc_hub_p = v(xdut.aop)
let dc_hub_n = v(xdut.aon)
let i_vsup_ua = abs(i(vsup))*1e6
let vbias_anchor_mv = v(ibn)*1e3
print i_vsup_ua
print vbias_anchor_mv
print dc_hub_p
print dc_hub_n
noise v(xdut.aop,xdut.aon) vd dec 20 1 1e9
noise v(xdut.aop,xdut.aon) vd dec 20 1e3 1e9
ac dec 20 1 1e9
let m_hub_av_dc = mag(v(xdut.aop)-v(xdut.aon))[0]
let m_hub_onoise_uv = noise2.onoise_total*1e6
let m_hub_onoise_hf_uv = noise4.onoise_total*1e6
let m_hub_vn_in_uv = noise2.onoise_total/m_hub_av_dc*1e6
let m_hub_vn_in_hf_uv = noise4.onoise_total/m_hub_av_dc*1e6
let m_hub_inoise_band_uv = noise2.inoise_total*1e6
let m_hub_white_nv_rthz = noise1.onoise_spectrum[120]*1e9
let m_hub_enbw_mhz = (noise2.onoise_total^2)/(noise1.onoise_spectrum[120]^2)/1e6
print m_hub_av_dc
print m_hub_onoise_uv
print m_hub_onoise_hf_uv
print m_hub_vn_in_uv
print m_hub_vn_in_hf_uv
print m_hub_inoise_band_uv
print m_hub_white_nv_rthz
print m_hub_enbw_mhz
.endc
.end
