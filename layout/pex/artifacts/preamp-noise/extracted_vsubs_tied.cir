* extracted_vsubs_tied -- GENERATED by layout/pex/preamp_noise_probe.py (issue #202), do not edit
.param vdd_nom=3.3
.param vdd_val=3.3
.param temp_c=27.0
.param dut_ib=1e-05
.param dut_vcm=1.65
.include "/home/ubuntu/.volare/gf180mcuD/libs.tech/ngspice/design.ngspice"
.lib "/home/ubuntu/.volare/gf180mcuD/libs.tech/ngspice/sm141064.ngspice" typical
.lib "/home/ubuntu/.volare/gf180mcuD/libs.tech/ngspice/sm141064.ngspice" res_typical
.lib "/home/ubuntu/.volare/gf180mcuD/libs.tech/ngspice/sm141064.ngspice" bjt_typical
.lib "/home/ubuntu/.volare/gf180mcuD/libs.tech/ngspice/sm141064.ngspice" diode_typical
.lib "/home/ubuntu/.volare/gf180mcuD/libs.tech/ngspice/sm141064.ngspice" moscap_typical
.lib "/home/ubuntu/.volare/gf180mcuD/libs.tech/ngspice/sm141064.ngspice" mimcap_typical
.temp 27.0
.include "/home/ubuntu/GitHub/gf180-comparator/.loom/worktrees/issue-202/layout/pex/artifacts/preamp-noise/comparator.dut-layout.cir"

vsup vdd 0 dc {vdd_val}
vcm  cm 0 dc {dut_vcm}
vd   vd 0 dc 0 ac 1
Eap  ap cm vd 0 0.5
Ean  an cm vd 0 -0.5
ib   vdd ibn dc {dut_ib}
* the WHOLE comparator, held in reset (clk low)
vclk clk 0 dc 0
Xdut ap an clk ibn dout doutb vdd 0 comparator_dut
* SENSITIVITY ONLY: tie the extraction's global substrate node to 0 V.
* The extraction ties it to 0 through 1e12 ohm, i.e. floating for AC.
Vsubs_sens vsubs 0 dc 0

.control
set numdgt=10
set noaskquit
op
let dc_hub_p = v(xdut.xlayout_dut.aop)
let dc_hub_n = v(xdut.xlayout_dut.aon)
let dc_drain_leg_p = v(xdut.xlayout_dut.aop__t1)
let dc_drain_leg_n = v(xdut.xlayout_dut.aon__t1)
let i_vsup_ua = abs(i(vsup))*1e6
let vbias_anchor_mv = v(ibn)*1e3
print i_vsup_ua
print vbias_anchor_mv
print dc_hub_p
print dc_hub_n
print dc_drain_leg_p
print dc_drain_leg_n
noise v(xdut.xlayout_dut.aop,xdut.xlayout_dut.aon) vd dec 20 1 1e9
noise v(xdut.xlayout_dut.aop,xdut.xlayout_dut.aon) vd dec 20 1e3 1e9
noise v(xdut.xlayout_dut.aop__t1,xdut.xlayout_dut.aon__t1) vd dec 20 1 1e9
noise v(xdut.xlayout_dut.aop__t1,xdut.xlayout_dut.aon__t1) vd dec 20 1e3 1e9
ac dec 20 1 1e9
let m_hub_av_dc = mag(v(xdut.xlayout_dut.aop)-v(xdut.xlayout_dut.aon))[0]
let m_hub_onoise_uv = noise2.onoise_total*1e6
let m_hub_onoise_hf_uv = noise4.onoise_total*1e6
let m_hub_vn_in_uv = noise2.onoise_total/m_hub_av_dc*1e6
let m_hub_vn_in_hf_uv = noise4.onoise_total/m_hub_av_dc*1e6
let m_hub_inoise_band_uv = noise2.inoise_total*1e6
let m_hub_white_nv_rthz = noise1.onoise_spectrum[120]*1e9
let m_hub_enbw_mhz = (noise2.onoise_total^2)/(noise1.onoise_spectrum[120]^2)/1e6
let m_drain_leg_av_dc = mag(v(xdut.xlayout_dut.aop__t1)-v(xdut.xlayout_dut.aon__t1))[0]
let m_drain_leg_onoise_uv = noise6.onoise_total*1e6
let m_drain_leg_onoise_hf_uv = noise8.onoise_total*1e6
let m_drain_leg_vn_in_uv = noise6.onoise_total/m_drain_leg_av_dc*1e6
let m_drain_leg_vn_in_hf_uv = noise8.onoise_total/m_drain_leg_av_dc*1e6
let m_drain_leg_inoise_band_uv = noise6.inoise_total*1e6
let m_drain_leg_white_nv_rthz = noise5.onoise_spectrum[120]*1e9
let m_drain_leg_enbw_mhz = (noise6.onoise_total^2)/(noise5.onoise_spectrum[120]^2)/1e6
print m_hub_av_dc
print m_hub_onoise_uv
print m_hub_onoise_hf_uv
print m_hub_vn_in_uv
print m_hub_vn_in_hf_uv
print m_hub_inoise_band_uv
print m_hub_white_nv_rthz
print m_hub_enbw_mhz
print m_drain_leg_av_dc
print m_drain_leg_onoise_uv
print m_drain_leg_onoise_hf_uv
print m_drain_leg_vn_in_uv
print m_drain_leg_vn_in_hf_uv
print m_drain_leg_inoise_band_uv
print m_drain_leg_white_nv_rthz
print m_drain_leg_enbw_mhz
.endc
.end
