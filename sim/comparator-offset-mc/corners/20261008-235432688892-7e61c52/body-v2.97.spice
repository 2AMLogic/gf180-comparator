* comparator-offset-mc -- GENERATED by sim/tools/mk_klt_request.py, do not edit
* dut=comparator-dr0001 (schematic) sha256=79dcc79fb6a876bc
.param vdd_nom=3.3
.param vdd_val=2.97
.param temp_c=27.0
.param dut_ib=1e-05
.param dut_vcm=1.65
.param dut_vos=0.0
Eddprobe dd 0 aop aon 1
.include "design.ngspice"
.include "/home/ubuntu/GitHub/gf180-comparator/.loom/worktrees/issue-102/design/comparator.spice"
.include "/home/ubuntu/GitHub/gf180-comparator/.loom/worktrees/issue-102/sim/comparator-offset-mc/testbench/tb_offset_mc.spice"
