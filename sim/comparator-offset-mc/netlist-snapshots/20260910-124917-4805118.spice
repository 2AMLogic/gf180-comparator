* Netlist snapshot for record 20260910-124917-4805118 -- exactly what was simulated.
* DUT: comparator-dr0001 (schematic), design/comparator.spice
* Testbench: sim/comparator-offset-mc/testbench/tb_offset_mc.spice
* ---------------- DUT NETLIST ----------------
* ===========================================================================
* GENERATED FILE -- do not edit. Regenerate with:  ./design/netlist.sh
*
* Source of truth: design/comparator.sch and the cells below it
*   design/comparator_dut.sch        -> .subckt comparator_dut
*   design/comparator_dut_analog.sch -> .subckt comparator_dut_analog
*   design/comparator_dut_latch.sch  -> .subckt comparator_dut_latch
*
* Topology, sizing and the gm/ID rows every device is cited against:
*   spec/decision-records/DR-0001-comparator-topology.md
*
* Interface contract (pin names and ORDER) : sim/dut/README.md
* Bound into the corner runner by          : sim/dut.json
*
* This file deliberately contains no .include / .lib / .temp / .control /
* .endc / .end: the harness supplies the models, the corner .lib sections,
* the temperature and the control block for every PVT point it composes.
* ===========================================================================
** sch_path: design/comparator.sch

* expanding   symbol:  comparator_dut.sym # of pins=8
** sym_path: design/comparator_dut.sym
** sch_path: design/comparator_dut.sch
.subckt comparator_dut vinp vinn clk ibias dout doutb vdd vss

*.ipin vinp
*.ipin vinn
*.ipin clk
*.ipin ibias
*.opin dout
*.opin doutb
*.iopin vdd
*.iopin vss
XA vinp vinn ibias aop aon vdd vss comparator_dut_analog
XL aop aon clk dout doutb vdd vss comparator_dut_latch
.ends

* expanding   symbol:  comparator_dut_analog.sym # of pins=7
** sym_path: design/comparator_dut_analog.sym
** sch_path: design/comparator_dut_analog.sch
.subckt comparator_dut_analog vinp vinn ibias aop aon vdd vss

*.ipin vinp
*.ipin vinn
*.ipin ibias
*.opin aop
*.opin aon
*.iopin vdd
*.iopin vss
XMB ibias ibias vss vss nfet_03v3 L=4u W=5u nf=1 ad='int((nf+1)/2) * W/nf * 0.18u' as='int((nf+2)/2) * W/nf * 0.18u' pd='2*int((nf+1)/2) * (W/nf + 0.18u)'
+ ps='2*int((nf+2)/2) * (W/nf + 0.18u)' nrd='0.18u / W' nrs='0.18u / W' sa=0 sb=0 sd=0 m=1
XMT atail ibias vss vss nfet_03v3 L=4u W=10u nf=1 ad='int((nf+1)/2) * W/nf * 0.18u' as='int((nf+2)/2) * W/nf * 0.18u' pd='2*int((nf+1)/2) * (W/nf + 0.18u)'
+ ps='2*int((nf+2)/2) * (W/nf + 0.18u)' nrd='0.18u / W' nrs='0.18u / W' sa=0 sb=0 sd=0 m=1
XMIP aon vinp atail vss nfet_03v3 L=2u W=30u nf=1 ad='int((nf+1)/2) * W/nf * 0.18u' as='int((nf+2)/2) * W/nf * 0.18u' pd='2*int((nf+1)/2) * (W/nf + 0.18u)'
+ ps='2*int((nf+2)/2) * (W/nf + 0.18u)' nrd='0.18u / W' nrs='0.18u / W' sa=0 sb=0 sd=0 m=1
XMIN aop vinn atail vss nfet_03v3 L=2u W=30u nf=1 ad='int((nf+1)/2) * W/nf * 0.18u' as='int((nf+2)/2) * W/nf * 0.18u' pd='2*int((nf+1)/2) * (W/nf + 0.18u)'
+ ps='2*int((nf+2)/2) * (W/nf + 0.18u)' nrd='0.18u / W' nrs='0.18u / W' sa=0 sb=0 sd=0 m=1
XRN aon vdd vss ppolyf_u_1k r_width=1u r_length=120u m=1
XRP aop vdd vss ppolyf_u_1k r_width=1u r_length=120u m=1
.ends

* expanding   symbol:  comparator_dut_latch.sym # of pins=7
** sym_path: design/comparator_dut_latch.sym
** sch_path: design/comparator_dut_latch.sch
.subckt comparator_dut_latch inp inn clk dout doutb vdd vss

*.ipin inp
*.ipin inn
*.ipin clk
*.opin dout
*.opin doutb
*.iopin vdd
*.iopin vss
XMTL ltail clk vss vss nfet_03v3 L=0.5u W=16u nf=1 ad='int((nf+1)/2) * W/nf * 0.18u' as='int((nf+2)/2) * W/nf * 0.18u' pd='2*int((nf+1)/2) * (W/nf + 0.18u)'
+ ps='2*int((nf+2)/2) * (W/nf + 0.18u)' nrd='0.18u / W' nrs='0.18u / W' sa=0 sb=0 sd=0 m=1
XM1 mn inp ltail vss nfet_03v3 L=0.5u W=8u nf=1 ad='int((nf+1)/2) * W/nf * 0.18u' as='int((nf+2)/2) * W/nf * 0.18u' pd='2*int((nf+1)/2) * (W/nf + 0.18u)'
+ ps='2*int((nf+2)/2) * (W/nf + 0.18u)' nrd='0.18u / W' nrs='0.18u / W' sa=0 sb=0 sd=0 m=1
XM2 mp inn ltail vss nfet_03v3 L=0.5u W=8u nf=1 ad='int((nf+1)/2) * W/nf * 0.18u' as='int((nf+2)/2) * W/nf * 0.18u' pd='2*int((nf+1)/2) * (W/nf + 0.18u)'
+ ps='2*int((nf+2)/2) * (W/nf + 0.18u)' nrd='0.18u / W' nrs='0.18u / W' sa=0 sb=0 sd=0 m=1
XM3 qn qp mn vss nfet_03v3 L=0.5u W=6u nf=1 ad='int((nf+1)/2) * W/nf * 0.18u' as='int((nf+2)/2) * W/nf * 0.18u' pd='2*int((nf+1)/2) * (W/nf + 0.18u)'
+ ps='2*int((nf+2)/2) * (W/nf + 0.18u)' nrd='0.18u / W' nrs='0.18u / W' sa=0 sb=0 sd=0 m=1
XM4 qp qn mp vss nfet_03v3 L=0.5u W=6u nf=1 ad='int((nf+1)/2) * W/nf * 0.18u' as='int((nf+2)/2) * W/nf * 0.18u' pd='2*int((nf+1)/2) * (W/nf + 0.18u)'
+ ps='2*int((nf+2)/2) * (W/nf + 0.18u)' nrd='0.18u / W' nrs='0.18u / W' sa=0 sb=0 sd=0 m=1
XM5 qn qp vdd vdd pfet_03v3 L=0.5u W=6u nf=1 ad='int((nf+1)/2) * W/nf * 0.18u' as='int((nf+2)/2) * W/nf * 0.18u' pd='2*int((nf+1)/2) * (W/nf + 0.18u)'
+ ps='2*int((nf+2)/2) * (W/nf + 0.18u)' nrd='0.18u / W' nrs='0.18u / W' sa=0 sb=0 sd=0 m=1
XM6 qp qn vdd vdd pfet_03v3 L=0.5u W=6u nf=1 ad='int((nf+1)/2) * W/nf * 0.18u' as='int((nf+2)/2) * W/nf * 0.18u' pd='2*int((nf+1)/2) * (W/nf + 0.18u)'
+ ps='2*int((nf+2)/2) * (W/nf + 0.18u)' nrd='0.18u / W' nrs='0.18u / W' sa=0 sb=0 sd=0 m=1
XM7 qn clk vdd vdd pfet_03v3 L=0.5u W=4u nf=1 ad='int((nf+1)/2) * W/nf * 0.18u' as='int((nf+2)/2) * W/nf * 0.18u' pd='2*int((nf+1)/2) * (W/nf + 0.18u)'
+ ps='2*int((nf+2)/2) * (W/nf + 0.18u)' nrd='0.18u / W' nrs='0.18u / W' sa=0 sb=0 sd=0 m=1
XM8 qp clk vdd vdd pfet_03v3 L=0.5u W=4u nf=1 ad='int((nf+1)/2) * W/nf * 0.18u' as='int((nf+2)/2) * W/nf * 0.18u' pd='2*int((nf+1)/2) * (W/nf + 0.18u)'
+ ps='2*int((nf+2)/2) * (W/nf + 0.18u)' nrd='0.18u / W' nrs='0.18u / W' sa=0 sb=0 sd=0 m=1
XM9 mn clk vdd vdd pfet_03v3 L=0.5u W=2u nf=1 ad='int((nf+1)/2) * W/nf * 0.18u' as='int((nf+2)/2) * W/nf * 0.18u' pd='2*int((nf+1)/2) * (W/nf + 0.18u)'
+ ps='2*int((nf+2)/2) * (W/nf + 0.18u)' nrd='0.18u / W' nrs='0.18u / W' sa=0 sb=0 sd=0 m=1
XM10 mp clk vdd vdd pfet_03v3 L=0.5u W=2u nf=1 ad='int((nf+1)/2) * W/nf * 0.18u' as='int((nf+2)/2) * W/nf * 0.18u' pd='2*int((nf+1)/2) * (W/nf + 0.18u)'
+ ps='2*int((nf+2)/2) * (W/nf + 0.18u)' nrd='0.18u / W' nrs='0.18u / W' sa=0 sb=0 sd=0 m=1
XIP1 sp qp vdd vdd pfet_03v3 L=0.5u W=5u nf=1 ad='int((nf+1)/2) * W/nf * 0.18u' as='int((nf+2)/2) * W/nf * 0.18u' pd='2*int((nf+1)/2) * (W/nf + 0.18u)'
+ ps='2*int((nf+2)/2) * (W/nf + 0.18u)' nrd='0.18u / W' nrs='0.18u / W' sa=0 sb=0 sd=0 m=1
XIN1 sp qp vss vss nfet_03v3 L=0.5u W=2u nf=1 ad='int((nf+1)/2) * W/nf * 0.18u' as='int((nf+2)/2) * W/nf * 0.18u' pd='2*int((nf+1)/2) * (W/nf + 0.18u)'
+ ps='2*int((nf+2)/2) * (W/nf + 0.18u)' nrd='0.18u / W' nrs='0.18u / W' sa=0 sb=0 sd=0 m=1
XIP2 sn qn vdd vdd pfet_03v3 L=0.5u W=5u nf=1 ad='int((nf+1)/2) * W/nf * 0.18u' as='int((nf+2)/2) * W/nf * 0.18u' pd='2*int((nf+1)/2) * (W/nf + 0.18u)'
+ ps='2*int((nf+2)/2) * (W/nf + 0.18u)' nrd='0.18u / W' nrs='0.18u / W' sa=0 sb=0 sd=0 m=1
XIN2 sn qn vss vss nfet_03v3 L=0.5u W=2u nf=1 ad='int((nf+1)/2) * W/nf * 0.18u' as='int((nf+2)/2) * W/nf * 0.18u' pd='2*int((nf+1)/2) * (W/nf + 0.18u)'
+ ps='2*int((nf+2)/2) * (W/nf + 0.18u)' nrd='0.18u / W' nrs='0.18u / W' sa=0 sb=0 sd=0 m=1
XA1P na sp vdd vdd pfet_03v3 L=0.5u W=10u nf=1 ad='int((nf+1)/2) * W/nf * 0.18u' as='int((nf+2)/2) * W/nf * 0.18u' pd='2*int((nf+1)/2) * (W/nf + 0.18u)'
+ ps='2*int((nf+2)/2) * (W/nf + 0.18u)' nrd='0.18u / W' nrs='0.18u / W' sa=0 sb=0 sd=0 m=1
XA2P dout doutb na vdd pfet_03v3 L=0.5u W=10u nf=1 ad='int((nf+1)/2) * W/nf * 0.18u' as='int((nf+2)/2) * W/nf * 0.18u' pd='2*int((nf+1)/2) * (W/nf + 0.18u)'
+ ps='2*int((nf+2)/2) * (W/nf + 0.18u)' nrd='0.18u / W' nrs='0.18u / W' sa=0 sb=0 sd=0 m=1
XA1N dout sp vss vss nfet_03v3 L=0.5u W=2u nf=1 ad='int((nf+1)/2) * W/nf * 0.18u' as='int((nf+2)/2) * W/nf * 0.18u' pd='2*int((nf+1)/2) * (W/nf + 0.18u)'
+ ps='2*int((nf+2)/2) * (W/nf + 0.18u)' nrd='0.18u / W' nrs='0.18u / W' sa=0 sb=0 sd=0 m=1
XA2N dout doutb vss vss nfet_03v3 L=0.5u W=2u nf=1 ad='int((nf+1)/2) * W/nf * 0.18u' as='int((nf+2)/2) * W/nf * 0.18u' pd='2*int((nf+1)/2) * (W/nf + 0.18u)'
+ ps='2*int((nf+2)/2) * (W/nf + 0.18u)' nrd='0.18u / W' nrs='0.18u / W' sa=0 sb=0 sd=0 m=1
XB1P nb sn vdd vdd pfet_03v3 L=0.5u W=10u nf=1 ad='int((nf+1)/2) * W/nf * 0.18u' as='int((nf+2)/2) * W/nf * 0.18u' pd='2*int((nf+1)/2) * (W/nf + 0.18u)'
+ ps='2*int((nf+2)/2) * (W/nf + 0.18u)' nrd='0.18u / W' nrs='0.18u / W' sa=0 sb=0 sd=0 m=1
XB2P doutb dout nb vdd pfet_03v3 L=0.5u W=10u nf=1 ad='int((nf+1)/2) * W/nf * 0.18u' as='int((nf+2)/2) * W/nf * 0.18u' pd='2*int((nf+1)/2) * (W/nf + 0.18u)'
+ ps='2*int((nf+2)/2) * (W/nf + 0.18u)' nrd='0.18u / W' nrs='0.18u / W' sa=0 sb=0 sd=0 m=1
XB1N doutb sn vss vss nfet_03v3 L=0.5u W=2u nf=1 ad='int((nf+1)/2) * W/nf * 0.18u' as='int((nf+2)/2) * W/nf * 0.18u' pd='2*int((nf+1)/2) * (W/nf + 0.18u)'
+ ps='2*int((nf+2)/2) * (W/nf + 0.18u)' nrd='0.18u / W' nrs='0.18u / W' sa=0 sb=0 sd=0 m=1
XB2N doutb dout vss vss nfet_03v3 L=0.5u W=2u nf=1 ad='int((nf+1)/2) * W/nf * 0.18u' as='int((nf+2)/2) * W/nf * 0.18u' pd='2*int((nf+1)/2) * (W/nf + 0.18u)'
+ ps='2*int((nf+2)/2) * (W/nf + 0.18u)' nrd='0.18u / W' nrs='0.18u / W' sa=0 sb=0 sd=0 m=1
.ends

* ---------------- TESTBENCH FRAGMENT ----------------
* tb_offset_mc -- Monte-Carlo input-referred offset of the comparator front
* end, and the part of that offset that MOVES with input common mode.
*
* Netlist FRAGMENT. The harness supplies the models, the corner .lib
* sections, .temp, the DUT netlist, the .control block and .end
* (sim/harness/README.md). Parameters from the harness: vdd_val, vdd_nom,
* temp_c, dut_ib, dut_vcm.
*
* METHODOLOGY PORTED FROM gf180-sar-adc/sim/comparator-offset-mc/ -- see this
* experiment's README.md for the full transfer/non-transfer list. In one
* line: `setseed <n>` once, then N draws through a `dowhile`/`reset` loop,
* each draw re-evaluating the agauss expressions inside the PDK's `fets_mm`
* subcircuits, with the gain of the SAME draw measured by a second DC point
* so that offset = -dv0/A_v is a real offset rather than a difference of two
* independent populations.
*
* STANDALONE STIMULUS. gf180-sar-adc's version of this bench sweeps the
* common-mode band its CDAC produces in single-ended mode. There is no CDAC
* here and no SAR sequencer: the stimulus is an ideal differential DC source
* riding on an ideal common-mode source, and the common-mode band swept is a
* stated +/-50 mV about the DUT's own specified `dut_vcm` -- a property of
* the comparator, not of anything driving it.
*
* MISMATCH IS TURNED ON HERE, IN THE FRAGMENT, NOT IN THE MANIFEST'S params.
* The harness emits manifest params AHEAD of the model includes, and
* design.ngspice sets sw_stat_mismatch = 0; a manifest param would therefore
* be silently overridden and the entire Monte Carlo would collapse to
* sigma = 0 while still looking like it ran. Setting it after the includes
* (this fragment is included after them) is the only placement that works.

.param sw_stat_mismatch=1

.param c_route=10f
.param vcm_step=50m

* ---- supply ----------------------------------------------------------
vsup vdd 0 dc {vdd_val}

* ---- ideal standalone stimulus ---------------------------------------
* cm  = dut_vcm + vcmd, so sweeping `vcmd` moves the input common mode
* without the manifest having to know what dut_vcm is.
vcmb cmb 0 dc {dut_vcm}
vcmd cm  cmb dc 0
vd   vd 0 dc 0
Eap  ap cm vd 0 0.5
Ean  an cm vd 0 -0.5

* ---- device under test (front end; see sim/dut/README.md) -------------
ib   vdd ibn dc {dut_ib}
Xa   ap an ibn aop aon vdd 0 comparator_dut_analog

* Routing allowance on each front-end output. Deliberately SMALL: loading
* this node harder would only lower the bandwidth, which does not affect a
* DC offset measurement, but keeping the same allowance as the noise bench
* means the two benches see the same circuit.
Cwp aop 0 {c_route}
Cwn aon 0 {c_route}

* ---- NULL CONTROL: resistor local mismatch ---------------------------
* Two identical unsalicided poly resistors, each fed 1 uA, read as the
* difference of their terminal voltages. EXPECTED TO BE EXACTLY ZERO:
* gf180mcu wires `*(1+mis_r*sw_stat_mismatch)` into its resistor subcircuits
* but hard-sets mis_r = 0 and leaves the area-scaled agauss expression
* commented out, so this PDK models NO resistor local mismatch at all.
* Keeping it as a live check rather than a comment makes it a regression
* guard: a PDK revision that switches mis_r on fails here instead of
* silently changing the meaning of every offset record in this repo. It also
* states, in the record itself, that the reported offset sigma contains no
* load-mismatch term and that such a term must be budgeted by hand.
irefa 0 rpa dc 1u
Xra   rpa 0 0 ppolyf_u_1k r_width=1u r_length=100u
irefb 0 rpb dc 1u
Xrb   rpb 0 0 ppolyf_u_1k r_width=1u r_length=100u
