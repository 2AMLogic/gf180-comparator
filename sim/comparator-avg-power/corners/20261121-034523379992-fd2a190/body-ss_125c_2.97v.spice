* comparator-avg-power -- GENERATED by sim/tools/mk_klt_request.py, do not edit
* dut=comparator-dr0001-layout (extracted) sha256=796431fd771e080d
* source-sha256 796431fd771e080d82491fdd9e6b5b7809fa76212a61cace42139128dbf2dbf6 sources/dut/comparator.dut-layout.spice
* source-sha256 0c3561ab929e88c25421e8ec10dd3c60f2c02fe73050c2dabacbf04497316636 sources/dut-binding.json
* source-sha256 ad9454f781c63108fa9997c293f3477f45e63954928dd872e7d82ff2f5d936a1 sources/testbench/tb.json
* source-sha256 a2bb5545b89137e1f21332108f28575697b771b05030bc829ee0eea26051986e sources/testbench/tb_avg_power.spice
* source-sha256 35c7012038e6ffadf3db48e3b34982d93157f36e493d2e526a710c4fe5bc144f sources/testbench/tb_vosprobe.spice
.param vdd_nom=3.3
.param vdd_val=2.97
.param temp_c=27.0
.param dut_ib=1e-05
.param dut_vcm=1.65
.param dut_vos=-0.005299225715919995
.param f_clk=32000000.0
.param t_per=3.125e-08
.param t_hi=1.5625e-08
.param t_edge=1e-10
.param t_rise0=1e-08
.param n_warm=8
.param n_win=16
.param v_od=0.01
.param c_load=2e-14
.param t_setup=1e-08
.include "design.ngspice"
.options reltol=1e-4
.options vntol=1e-9
.options abstol=1e-13
.include "sources/dut/comparator.dut-layout.spice"
.include "sources/testbench/tb_avg_power.spice"
