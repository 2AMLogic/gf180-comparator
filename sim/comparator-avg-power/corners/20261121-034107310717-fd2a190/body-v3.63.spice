* comparator-avg-power -- GENERATED by sim/tools/mk_klt_request.py, do not edit
* dut=comparator-dr0001 (schematic) sha256=0df618e73b1f0736
* source-sha256 0df618e73b1f0736aac33c786eac58e5a7381f55b3a4e41dc4eb56d9a8ad0d8a sources/dut/comparator.spice
* source-sha256 9ed024b2e635e241570e47b0e48c2fbe8719c0c4dbd38c92b7e97c1b06e49701 sources/dut-binding.json
* source-sha256 ad9454f781c63108fa9997c293f3477f45e63954928dd872e7d82ff2f5d936a1 sources/testbench/tb.json
* source-sha256 a2bb5545b89137e1f21332108f28575697b771b05030bc829ee0eea26051986e sources/testbench/tb_avg_power.spice
* source-sha256 35c7012038e6ffadf3db48e3b34982d93157f36e493d2e526a710c4fe5bc144f sources/testbench/tb_vosprobe.spice
.param vdd_nom=3.3
.param vdd_val=3.63
.param temp_c=27.0
.param dut_ib=1e-05
.param dut_vcm=1.65
.param dut_vos=0.0
.param f_clk=32000000.0
.param t_per=3.125e-08
.param t_hi=1.5625e-08
.param t_edge=1e-10
.param t_rise0=1e-08
.param n_warm=8
.param n_win=16
.param v_od=0.01
.param c_load=2e-14
.param t_setup=1e-08
.include "design.ngspice"
.options reltol=1e-4
.options vntol=1e-9
.options abstol=1e-13
.include "sources/dut/comparator.spice"
.include "sources/testbench/tb_avg_power.spice"
