* Netlist snapshot for record 20260909-055524-e2bb637 -- exactly what was simulated.
* DUT: placeholder-v1 (placeholder), sim/dut/placeholder_comparator.spice
* Testbench: sim/comparator-preamp-noise/testbench/tb_preamp_noise.spice
* ---------------- DUT NETLIST ----------------
* ============================================================================
* PLACEHOLDER DUT -- NOT A DESIGN, NOT A TOPOLOGY PROPOSAL
* ============================================================================
*
* This netlist exists for exactly one reason: so that sim/'s harness, its
* corner grid, its evidence-record format and its four experiment benches can
* be proven to run end to end BEFORE this repo's comparator topology has been
* decided. That decision is spec/porting-plan.md next step 1 and is a separate
* decision record; it is explicitly out of scope for the harness work.
*
* Consequences, stated so nobody has to infer them:
*
*   - NOTHING HERE IS SIZED. The devices are round numbers picked by
*     inspection to give a converging operating point at 3.3 V. No gm/ID
*     study, no noise budget, no offset budget went into any of them.
*   - NO NUMBER MEASURED AGAINST THIS DUT SUBSTANTIATES A SPEC ROW.
*     sim/dut.json declares provenance "placeholder", which makes every
*     record the harness writes against it carry a banner saying so.
*   - THIS IS NOT gf180-sar-adc's COMPARATOR. spec/porting-plan.md ports that
*     repo's testbench METHODOLOGY and forbids porting its topology, sizing
*     or numbers. The front end below is a textbook resistively-loaded
*     differential pair at deliberately different, deliberately unconsidered
*     sizing; the decision stage below is BEHAVIOURAL and therefore commits
*     to no transistor topology at all.
*
* When design/comparator.sch (or its netlist) lands, point sim/dut.json at it
* and re-run. Nothing else in sim/ changes.
*
* Interface contract: sim/dut/README.md.
* Parameters supplied by the harness: dut_ib, dut_vcm, vdd_val, vdd_nom,
* temp_c (sim/harness/runner.py compose_deck).
* ============================================================================

* ---------------------------------------------------------------------------
* comparator_dut_analog -- the DC-resolvable front end.
*
* Exposed as its own subckt because two of the four experiments (offset-MC
* and preamp-noise) are small-signal analyses about a DC operating point.
* See sim/dut/README.md "Why there are two subckts".
*
* Simple NMOS-input pair, 1:1 tail mirror, unsalicided p+ poly loads.
* w/l are round numbers. Do not read intent into them.
* ---------------------------------------------------------------------------
.subckt comparator_dut_analog vinp vinn ibias aop aon vdd vss
* 1:1 NMOS current mirror; ibias is forced into the diode branch.
Xmb  ibias ibias vss vss nfet_03v3 w=10u l=1u
Xmt  atail ibias vss vss nfet_03v3 w=10u l=1u
* Input pair. The device whose gate is vinp drives the INVERTING node aon,
* so v(aop) - v(aon) = +A_v * (v(vinp) - v(vinn)).
Xmip aon vinp atail vss nfet_03v3 w=20u l=1u
Xmin aop vinn atail vss nfet_03v3 w=20u l=1u
* Unsalicided 1 kohm/sq p+ poly loads, 100 squares = 100 kohm nominal.
* Third terminal is the substrate/body contact. `ppolyf_u_1k` is chosen
* because it is the flavour klayout-tools' gf180mcu extraction deck can
* actually select today (2AMLogic/klayout-tools#595, cited in
* spec/porting-plan.md) -- so a placeholder that is later replaced by a real
* design does not hand the layout work an already-known dead end.
Xrlp vdd aop vss ppolyf_u_1k r_width=1u r_length=100u
Xrln vdd aon vss ppolyf_u_1k r_width=1u r_length=100u
.ends comparator_dut_analog

* ---------------------------------------------------------------------------
* comparator_dut_latch -- BEHAVIOURAL regenerative decision stage.
*
* Deliberately behavioural. A transistor-level latch here would be a topology
* choice, and the topology decision is out of scope. What this models is only
* the *observable contract* every latched comparator has, so that the
* regeneration and kickback benches have something real to measure:
*
*   clk low   -> reset: both regeneration nodes pulled to mid-rail
*   clk high  -> evaluate: dv/dt = dv/tau + (input injection), i.e. the
*                exponential regeneration law t = t0 + tau*ln(V/(A*Vin))
*                the regeneration bench extracts tau from
*   output    -> held between decisions, flipping only once the regeneration
*                nodes have separated past an absolute threshold (an SR
*                latch's behaviour, not a differential zero-crossing)
*
* c_fb IS THE PART THAT MATTERS FOR KICKBACK and it is an explicit, declared
* stand-in: a real latch's input pair couples its rail-to-rail regeneration
* nodes back to its inputs through C_gd. Modelling that as an explicit 5 fF
* per side means the kickback bench measures a real path (regeneration node
* -> front-end output -> input-pair C_gd -> input node) instead of reporting
* a fictitious zero. The VALUE is a placeholder like everything else here.
* ---------------------------------------------------------------------------
.subckt comparator_dut_latch inp inn clk dout doutb vdd vss
.param g_reg=5m
.param c_reg=500f
.param g_in=5m
.param v_lim=0.4
.param c_fb=5f
.param g_clamp=1
.param r_hold=200
.param c_hold=100f
.param v_th=0.8
.param v_sharp=0.1
.param r_rst=100
* Clock enable, smoothed so the B-source expressions stay differentiable.
Ben  ken 0 v = '0.5*(1+tanh((v(clk)-0.5*v(vdd,vss))/0.05))'
Cqp  qp 0 {c_reg}
Cqn  qn 0 {c_reg}
* Positive feedback (tanh-limited) plus input injection. tau = c_reg/(2*g_reg).
Bqp  0 qp i = 'v(ken)*( g_reg*v_lim*tanh((v(qp)-v(qn))/v_lim) + g_in*(v(inp)-v(inn)) )'
Bqn  0 qn i = '-v(ken)*( g_reg*v_lim*tanh((v(qp)-v(qn))/v_lim) + g_in*(v(inp)-v(inn)) )'
* Reset to mid-rail while clk is low.
Brp  0 qp i = '(1-v(ken))*(0.5*v(vdd,vss)-v(qp))/r_rst'
Brn  0 qn i = '(1-v(ken))*(0.5*v(vdd,vss)-v(qn))/r_rst'
* Rail clamps -- the regeneration nodes are supply-bounded, like real ones.
Bcp  qp 0 i = 'g_clamp*(max(v(qp)-v(vdd),0)+min(v(qp)-v(vss),0))'
Bcn  qn 0 i = 'g_clamp*(max(v(qn)-v(vdd),0)+min(v(qn)-v(vss),0))'
* Latch input pair C_gd, explicit. This is the kickback path (see header).
Ckp  qp inp {c_fb}
Ckn  qn inn {c_fb}
* Output hold. Tracks the decision only once |v(qp)-v(qn)| passes v_th, so
* the output delay is a real function of overdrive rather than of the moment
* the differential crosses zero. Rh keeps the node non-floating for `op`.
Ch   h 0 {c_hold}
Rh   h vss 1G
Bh   0 h i = 'v(ken)*0.5*(1+tanh((abs(v(qp)-v(qn))-v_th)/v_sharp))*(v(vdd,vss)*0.5*(1+tanh((v(qp)-v(qn))/v_sharp))-v(h))/r_hold'
Bdo  dout  0 v = 'min(max(v(h),v(vss)),v(vdd))'
Bdob doutb 0 v = 'v(vdd)-min(max(v(h),v(vss)),v(vdd))'
.ends comparator_dut_latch

* ---------------------------------------------------------------------------
* comparator_dut -- the full clocked comparator the transient benches drive.
* ---------------------------------------------------------------------------
.subckt comparator_dut vinp vinn clk ibias dout doutb vdd vss
Xa vinp vinn ibias aop aon vdd vss comparator_dut_analog
Xl aop aon clk dout doutb vdd vss comparator_dut_latch
.ends comparator_dut

* ---------------- TESTBENCH FRAGMENT ----------------
* tb_preamp_noise -- input-referred noise of the comparator front end,
* measured with ngspice's `.noise` analysis, over the full PVT grid.
*
* Netlist FRAGMENT. The harness supplies the models, the corner .lib
* sections, .temp, the DUT netlist, the .control block and .end
* (sim/harness/README.md). Parameters from the harness: vdd_val, vdd_nom,
* temp_c, dut_ib, dut_vcm.
*
* METHODOLOGY PORTED FROM gf180-sar-adc/sim/comparator-preamp-noise/ -- see
* this experiment's README.md for the full transfer/non-transfer list.
*
* THE UNITS CAUTION THAT MADE THIS BENCH WORTH PORTING. ngspice's own
* `inoise_total` is its input referral through the AC transfer function of
* the source you name; the number this repo's README.md noise row is stated
* at is the TOTAL INTEGRATED OUTPUT NOISE DIVIDED BY THE MEASURED DC GAIN.
* The sibling repo's own record documents a prior 200x-magnitude error from
* reporting `sqrt(onoise_total)` directly as the answer. So this bench
* reports BOTH -- `vn_in_uv` (onoise_total / A_v, the number that is quoted)
* and `inoise_band_uv` (ngspice's own) -- and the record shows them side by
* side. If they ever disagree by more than the AC-vs-DC gain difference,
* something is wrong with the referral, and that is visible rather than
* hidden.
*
* WHY THIS BENCH CAN EXIST AT ALL. `.noise` is a small-signal analysis about
* a DC operating point. A reset-and-regenerate decision stage has none, and
* ngspice offers no PSS/pnoise and no automatic device-level transient noise.
* So this bench measures the FRONT END -- which is also where the dominant
* term is, since everything after it is divided by the front-end gain. The
* decision stage's own noise is not reachable this way and is not claimed
* here; sim/comparator-regeneration/'s 0.1 mV rung bounds the region where
* it would matter. See sim/dut/README.md "Why the DUT is split into three
* subckts" for what happens to this bench if the ratified topology turns out
* to have no DC-resolvable front end.
*
* THE DECISION STAGE IS INSTANTIATED HERE, WITH ITS CLOCK HELD LOW. It
* contributes no current in reset, but it presents the input capacitance
* that -- with the front-end load resistance -- sets the noise bandwidth.
* Leaving it out would under-load the node, OVER-state the bandwidth, and so
* OVER-state the noise; replacing it with an invented lumped capacitor would
* make the number depend on that invention. Neither is acceptable, so the
* real thing is instantiated in reset.
*
* WHAT IS MEASURED
*   vn_in_uv      total input-referred noise, 1 Hz .. 1 GHz, as
*                 onoise_total / A_v(DC). A comparator SAMPLES its input
*                 noise at the decision instant rather than filtering it, so
*                 the relevant quantity is the TOTAL integrated noise, not a
*                 density at some bandwidth.
*   vn_in_hf_uv   the same integrated from 1 kHz up. The difference in
*                 quadrature is the sub-kHz flicker content, which drifts
*                 slowly enough to behave as an offset rather than as
*                 per-decision noise. Reporting both keeps that distinction
*                 visible instead of burying it in one total.
*   av_dc, enbw   gain and equivalent noise bandwidth, so the noise number
*                 can be re-derived by hand as (density x sqrt(ENBW)).
*
* fnoicor. The flicker-corner switch is left at the PDK default
* (fnoicor = 0, as-extracted). The worst-case setting moves the gf180mcu
* flicker corner substantially, so every flicker number in this repo must
* state which setting it came from -- this one is the default, and the
* vn_in_uv / vn_in_hf_uv split above is what lets a reader rescale the
* flicker part and see whether it would change any verdict.

.param c_route=10f

vsup vdd 0 dc {vdd_val}

* ---- ideal standalone stimulus ---------------------------------------
* `vd` is the noise-analysis input source, so ngspice's own inoise_* is
* referred to the DIFFERENTIAL input directly and is comparable with the
* divide-by-gain number this bench actually quotes.
vcm  cm 0 dc {dut_vcm}
vd   vd 0 dc 0 ac 1
Eap  ap cm vd 0 0.5
Ean  an cm vd 0 -0.5

* ---- device under test ------------------------------------------------
ib   vdd ibn dc {dut_ib}
Xa   ap an ibn aop aon vdd 0 comparator_dut_analog

* Decision stage in reset: no current, but its input capacitance is part of
* the load that sets the front end's noise bandwidth.
vclk clk 0 dc 0
Xl   aop aon clk doutl doutbl vdd 0 comparator_dut_latch

* Routing allowance on each front-end output: a stated placeholder for
* interconnect that does not exist until a floorplan does. Kept deliberately
* SMALL, because loading this node harder would lower the noise bandwidth
* and so REDUCE the reported noise -- an optimistic direction. Under-loading
* it is the conservative choice, which means post-layout extraction can only
* improve this number, never worsen it.
Cwp aop 0 {c_route}
Cwn aon 0 {c_route}
