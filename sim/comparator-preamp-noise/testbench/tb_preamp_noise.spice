* tb_preamp_noise -- input-referred noise of the comparator front end,
* measured with ngspice's `.noise` analysis, over the full PVT grid.
*
* Netlist FRAGMENT. The harness supplies the models, the corner .lib
* sections, .temp, the DUT netlist, the .control block and .end
* (sim/harness/README.md). Parameters from the harness: vdd_val, vdd_nom,
* temp_c, dut_ib, dut_vcm.
*
* METHODOLOGY PORTED FROM gf180-sar-adc/sim/comparator-preamp-noise/ -- see
* this experiment's README.md for the full transfer/non-transfer list.
*
* THE UNITS CAUTION THAT MADE THIS BENCH WORTH PORTING. ngspice's own
* `inoise_total` is its input referral through the AC transfer function of
* the source you name; the number this repo's README.md noise row is stated
* at is the TOTAL INTEGRATED OUTPUT NOISE DIVIDED BY THE MEASURED DC GAIN.
* The sibling repo's own record documents a prior 200x-magnitude error from
* reporting `sqrt(onoise_total)` directly as the answer. So this bench
* reports BOTH -- `vn_in_uv` (onoise_total / A_v, the number that is quoted)
* and `inoise_band_uv` (ngspice's own) -- and the record shows them side by
* side. If they ever disagree by more than the AC-vs-DC gain difference,
* something is wrong with the referral, and that is visible rather than
* hidden.
*
* WHY THIS BENCH CAN EXIST AT ALL. `.noise` is a small-signal analysis about
* a DC operating point. A reset-and-regenerate decision stage has none, and
* ngspice offers no PSS/pnoise and no automatic device-level transient noise.
* So this bench measures the FRONT END -- which is also where the dominant
* term is, since everything after it is divided by the front-end gain. The
* decision stage's own noise is not reachable this way and is not claimed
* here; sim/comparator-regeneration/'s 0.1 mV rung bounds the region where
* it would matter. See sim/dut/README.md "Why the DUT is split into three
* subckts" for what happens to this bench if the ratified topology turns out
* to have no DC-resolvable front end.
*
* THE DECISION STAGE IS INSTANTIATED HERE, WITH ITS CLOCK HELD LOW. It
* contributes no current in reset, but it presents the input capacitance
* that -- with the front-end load resistance -- sets the noise bandwidth.
* Leaving it out would under-load the node, OVER-state the bandwidth, and so
* OVER-state the noise; replacing it with an invented lumped capacitor would
* make the number depend on that invention. Neither is acceptable, so the
* real thing is instantiated in reset.
*
* WHAT IS MEASURED
*   vn_in_uv      total input-referred noise, 1 Hz .. 1 GHz, as
*                 onoise_total / A_v(DC). A comparator SAMPLES its input
*                 noise at the decision instant rather than filtering it, so
*                 the relevant quantity is the TOTAL integrated noise, not a
*                 density at some bandwidth.
*   vn_in_hf_uv   the same integrated from 1 kHz up. The difference in
*                 quadrature is the sub-kHz flicker content, which drifts
*                 slowly enough to behave as an offset rather than as
*                 per-decision noise. Reporting both keeps that distinction
*                 visible instead of burying it in one total.
*   av_dc, enbw   gain and equivalent noise bandwidth, so the noise number
*                 can be re-derived by hand as (density x sqrt(ENBW)).
*
* fnoicor. The flicker-corner switch is left at the PDK default
* (fnoicor = 0, as-extracted). The worst-case setting moves the gf180mcu
* flicker corner substantially, so every flicker number in this repo must
* state which setting it came from -- this one is the default, and the
* vn_in_uv / vn_in_hf_uv split above is what lets a reader rescale the
* flicker part and see whether it would change any verdict.

.param c_route=10f

vsup vdd 0 dc {vdd_val}

* ---- ideal standalone stimulus ---------------------------------------
* `vd` is the noise-analysis input source, so ngspice's own inoise_* is
* referred to the DIFFERENTIAL input directly and is comparable with the
* divide-by-gain number this bench actually quotes.
vcm  cm 0 dc {dut_vcm}
vd   vd 0 dc 0 ac 1
Eap  ap cm vd 0 0.5
Ean  an cm vd 0 -0.5

* ---- device under test ------------------------------------------------
ib   vdd ibn dc {dut_ib}
Xa   ap an ibn aop aon vdd 0 comparator_dut_analog

* Decision stage in reset: no current, but its input capacitance is part of
* the load that sets the front end's noise bandwidth.
vclk clk 0 dc 0
Xl   aop aon clk doutl doutbl vdd 0 comparator_dut_latch

* Routing allowance on each front-end output: a stated placeholder for
* interconnect that does not exist until a floorplan does. Kept deliberately
* SMALL, because loading this node harder would lower the noise bandwidth
* and so REDUCE the reported noise -- an optimistic direction. Under-loading
* it is the conservative choice, which means post-layout extraction can only
* improve this number, never worsen it.
Cwp aop 0 {c_route}
Cwn aon 0 {c_route}
