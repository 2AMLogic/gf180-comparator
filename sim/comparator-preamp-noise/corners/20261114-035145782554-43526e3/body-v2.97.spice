* comparator-preamp-noise -- GENERATED by sim/tools/mk_klt_request.py, do not edit
* dut=comparator-dr0004-cascode-exp (schematic) sha256=79dcc79fb6a876bc
* source-sha256 79dcc79fb6a876bc46ab258af5eae3f2d24b3e41281df2c23d81897ddf34ed24 sources/dut/experiment_comparator_dr0004_cascode.spice
* source-sha256 7a94e29ac2751b285a86edb5d55956262a0708faaedb5f554e7391fb0f8b49c9 sources/dut-binding.json
* source-sha256 bd847cf431f1a779457794b2012bfc55f5f6de8c4bf590426db93b08940a4c69 sources/testbench/tb.json
* source-sha256 0aeaf85d9364b3e687f2f91c772c0f31d0dca1b7b46f9f768a8e7cfad8d98aa9 sources/testbench/tb_preamp_noise.spice
.param vdd_nom=3.3
.param vdd_val=2.97
.param temp_c=27.0
.param dut_ib=1e-05
.param dut_vcm=1.65
.param dut_vos=0.0
.include "design.ngspice"
.include "sources/dut/experiment_comparator_dr0004_cascode.spice"
.include "sources/testbench/tb_preamp_noise.spice"
