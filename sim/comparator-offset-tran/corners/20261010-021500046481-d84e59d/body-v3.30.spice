* comparator-offset-tran -- GENERATED by sim/tools/mk_klt_request.py, do not edit
* dut=comparator-dr0001 (schematic) sha256=0df618e73b1f0736
* source-sha256 0df618e73b1f0736aac33c786eac58e5a7381f55b3a4e41dc4eb56d9a8ad0d8a sources/dut/comparator.spice
* source-sha256 9ed024b2e635e241570e47b0e48c2fbe8719c0c4dbd38c92b7e97c1b06e49701 sources/dut-binding.json
* source-sha256 e1467070b403fd1fda4ee36325fca284ddc3c514da93123445328dec26f61bfb sources/testbench/tb.json
* source-sha256 1adfed227742098be0c5db0244f2ca248bb9420e8d8b3d5f13b4c2edc7d518fa sources/testbench/tb_offset_tran.spice
.param vdd_nom=3.3
.param vdd_val=3.3
.param temp_c=27.0
.param dut_ib=1e-05
.param dut_vcm=1.65
.param dut_vos=0.0
.param stair_t0_ns=4.0
.param stair_period_ns=24.0
.param stair_clk_high_ns=8.0
.param stair_v0_mv=-5.04
.param stair_step_mv=0.16
.param stair_levels=64
.param stair_lead_cycles=2
.param rmis_a_r_um=0.021
.param rmis_w_um=1.0
.param rmis_l_um=120.0
.param rmis_conservative_factor=3.0
.include "design.ngspice"
.include "sources/dut/comparator.spice"
.include "sources/testbench/tb_offset_tran.spice"
.control
set num_threads=1
.endc
