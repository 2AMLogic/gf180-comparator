* comparator-offset-cm-index -- GENERATED by sim/tools/mk_klt_request.py, do not edit
* dut=comparator-dr0001 (schematic) sha256=0df618e73b1f0736
* source-sha256 0df618e73b1f0736aac33c786eac58e5a7381f55b3a4e41dc4eb56d9a8ad0d8a sources/dut/comparator.spice
* source-sha256 9ed024b2e635e241570e47b0e48c2fbe8719c0c4dbd38c92b7e97c1b06e49701 sources/dut-binding.json
* source-sha256 8b164b74c2474a98aef743212a7770e73736f65ad4cd98e53b0fcec4b644c59d sources/testbench/tb.json
* source-sha256 014293424ecff1e2d81bc979e2d9eb5b8e28e346cecc1326be28125f0b5fc344 sources/testbench/tb_offset_cm_index.spice
.param vdd_nom=3.3
.param vdd_val=3.3
.param temp_c=27.0
.param dut_ib=1e-05
.param dut_vcm=1.65
.param dut_vos=0.0
.include "design.ngspice"
.include "sources/dut/comparator.spice"
.include "sources/testbench/tb_offset_cm_index.spice"
