* comparator-offset-tran-extracted-feasibility -- GENERATED by sim/tools/extracted_tran_feasibility.py, do not edit
* FEASIBILITY ONLY. dut=comparator-dr0001-layout (extracted) sha256=8ffe4ec2380516d2
* source-sha256 8ffe4ec2380516d266aea4284527771e9c96b7384780aea93477c11929f8348e sources/dut/comparator.dut-layout.spice
* source-sha256 3d87851854ee546c149af94f934fe9315411e4ac0079a41dcbf4ce632ac52861 sources/dut-binding.json
* source-sha256 7b577021e3100f078b6cf01d2248a1a10b73fa727568116cef12f37abdaf559c sources/testbench/tb.json
* source-sha256 c7063c072b4f505c6b7f46ece8fe713b8cd0d1210b6ffc2be7f00ed49501780a sources/testbench/tb_offset_tran_extracted.spice
* source-sha256 6ae89e60cdc0904d2ae938e2810d3be61e2c5385170a246d31df82a4365ee245 sources/testbench/tb_trip_probe.spice
.param vdd_nom=3.3
.param vdd_val=3.63
.param temp_c=27.0
.param dut_ib=1e-05
.param dut_vcm=1.65
.param dut_vos=0.0
.param stair_t0_ns=4.0
.param stair_period_ns=24.0
.param stair_clk_high_ns=8.0
.param stair_v0_mv=-5.04
.param stair_step_mv=0.16
.param stair_levels=64
.param stair_lead_cycles=2
.param stair_centre_mv=-21.57
vsd sd 0 pwl(0n -26.6100m 13n -26.6100m 14n -26.6100m 37n -26.6100m
+ 38n -26.6100m 61n -26.6100m 62n -26.4500m 85n -26.4500m 86n -26.2900m
+ 109n -26.2900m 110n -26.1300m 133n -26.1300m 134n -25.9700m
+ 157n -25.9700m 158n -25.8100m 181n -25.8100m 182n -25.6500m
+ 205n -25.6500m 206n -25.4900m 229n -25.4900m 230n -25.3300m
+ 253n -25.3300m 254n -25.1700m 277n -25.1700m 278n -25.0100m
+ 301n -25.0100m 302n -24.8500m 325n -24.8500m 326n -24.6900m
+ 349n -24.6900m 350n -24.5300m 373n -24.5300m 374n -24.3700m
+ 397n -24.3700m 398n -24.2100m 421n -24.2100m 422n -24.0500m
+ 445n -24.0500m 446n -23.8900m 469n -23.8900m 470n -23.7300m
+ 493n -23.7300m 494n -23.5700m 517n -23.5700m 518n -23.4100m
+ 541n -23.4100m 542n -23.2500m 565n -23.2500m 566n -23.0900m
+ 589n -23.0900m 590n -22.9300m 613n -22.9300m 614n -22.7700m
+ 637n -22.7700m 638n -22.6100m 661n -22.6100m 662n -22.4500m
+ 685n -22.4500m 686n -22.2900m 709n -22.2900m 710n -22.1300m
+ 733n -22.1300m 734n -21.9700m 757n -21.9700m 758n -21.8100m
+ 781n -21.8100m 782n -21.6500m 805n -21.6500m 806n -21.4900m
+ 829n -21.4900m 830n -21.3300m 853n -21.3300m 854n -21.1700m
+ 877n -21.1700m 878n -21.0100m 901n -21.0100m 902n -20.8500m
+ 925n -20.8500m 926n -20.6900m 949n -20.6900m 950n -20.5300m
+ 973n -20.5300m 974n -20.3700m 997n -20.3700m 998n -20.2100m
+ 1021n -20.2100m 1022n -20.0500m 1045n -20.0500m 1046n -19.8900m
+ 1069n -19.8900m 1070n -19.7300m 1093n -19.7300m 1094n -19.5700m
+ 1117n -19.5700m 1118n -19.4100m 1141n -19.4100m 1142n -19.2500m
+ 1165n -19.2500m 1166n -19.0900m 1189n -19.0900m 1190n -18.9300m
+ 1213n -18.9300m 1214n -18.7700m 1237n -18.7700m 1238n -18.6100m
+ 1261n -18.6100m 1262n -18.4500m 1285n -18.4500m 1286n -18.2900m
+ 1309n -18.2900m 1310n -18.1300m 1333n -18.1300m 1334n -17.9700m
+ 1357n -17.9700m 1358n -17.8100m 1381n -17.8100m 1382n -17.6500m
+ 1405n -17.6500m 1406n -17.4900m 1429n -17.4900m 1430n -17.3300m
+ 1453n -17.3300m 1454n -17.1700m 1477n -17.1700m 1478n -17.0100m
+ 1501n -17.0100m 1502n -16.8500m 1525n -16.8500m 1526n -16.6900m
+ 1549n -16.6900m 1550n -16.5300m 1573n -16.5300m 1574n -16.5300m
+ 1597n -16.5300m 1598n -16.5300m
+ )
Eddprobe dd 0 xa.xlayout_dut.aop xa.xlayout_dut.aon 1
Eapo apo 0 xa.xlayout_dut.aop 0 1
.include "design.ngspice"
.include "sources/dut/comparator.dut-layout.spice"
.include "sources/testbench/tb_offset_tran_extracted.spice"
.control
set num_threads=1
.endc
