* comparator-offset-tran-extracted-feasibility -- GENERATED by sim/tools/extracted_tran_feasibility.py, do not edit
* FEASIBILITY ONLY. dut=comparator-dr0001-layout (extracted) sha256=ab00c5ff7b53bd71
* source-sha256 ab00c5ff7b53bd7141715fc1e1dd3171982dca45e0b245eb4d073f010e6f5997 sources/dut/comparator.dut-layout-mm.spice
* source-sha256 c7d70417ed24e0065047ac94f7327fcaf252dc9196d5253cc97459d97099195d sources/dut-binding.json
* source-sha256 7b577021e3100f078b6cf01d2248a1a10b73fa727568116cef12f37abdaf559c sources/testbench/tb.json
* source-sha256 c7063c072b4f505c6b7f46ece8fe713b8cd0d1210b6ffc2be7f00ed49501780a sources/testbench/tb_offset_tran_extracted.spice
* source-sha256 6ae89e60cdc0904d2ae938e2810d3be61e2c5385170a246d31df82a4365ee245 sources/testbench/tb_trip_probe.spice
.param vdd_nom=3.3
.param vdd_val=3.63
.param temp_c=27.0
.param dut_ib=1e-05
.param dut_vcm=1.65
.param dut_vos=0.0
.param stair_t0_ns=4.0
.param stair_period_ns=24.0
.param stair_clk_high_ns=8.0
.param stair_v0_mv=-5.04
.param stair_step_mv=0.16
.param stair_levels=64
.param stair_lead_cycles=2
.param stair_centre_mv=-16.17
vsd sd 0 pwl(0n -21.2100m 13n -21.2100m 14n -21.2100m 37n -21.2100m
+ 38n -21.2100m 61n -21.2100m 62n -21.0500m 85n -21.0500m 86n -20.8900m
+ 109n -20.8900m 110n -20.7300m 133n -20.7300m 134n -20.5700m
+ 157n -20.5700m 158n -20.4100m 181n -20.4100m 182n -20.2500m
+ 205n -20.2500m 206n -20.0900m 229n -20.0900m 230n -19.9300m
+ 253n -19.9300m 254n -19.7700m 277n -19.7700m 278n -19.6100m
+ 301n -19.6100m 302n -19.4500m 325n -19.4500m 326n -19.2900m
+ 349n -19.2900m 350n -19.1300m 373n -19.1300m 374n -18.9700m
+ 397n -18.9700m 398n -18.8100m 421n -18.8100m 422n -18.6500m
+ 445n -18.6500m 446n -18.4900m 469n -18.4900m 470n -18.3300m
+ 493n -18.3300m 494n -18.1700m 517n -18.1700m 518n -18.0100m
+ 541n -18.0100m 542n -17.8500m 565n -17.8500m 566n -17.6900m
+ 589n -17.6900m 590n -17.5300m 613n -17.5300m 614n -17.3700m
+ 637n -17.3700m 638n -17.2100m 661n -17.2100m 662n -17.0500m
+ 685n -17.0500m 686n -16.8900m 709n -16.8900m 710n -16.7300m
+ 733n -16.7300m 734n -16.5700m 757n -16.5700m 758n -16.4100m
+ 781n -16.4100m 782n -16.2500m 805n -16.2500m 806n -16.0900m
+ 829n -16.0900m 830n -15.9300m 853n -15.9300m 854n -15.7700m
+ 877n -15.7700m 878n -15.6100m 901n -15.6100m 902n -15.4500m
+ 925n -15.4500m 926n -15.2900m 949n -15.2900m 950n -15.1300m
+ 973n -15.1300m 974n -14.9700m 997n -14.9700m 998n -14.8100m
+ 1021n -14.8100m 1022n -14.6500m 1045n -14.6500m 1046n -14.4900m
+ 1069n -14.4900m 1070n -14.3300m 1093n -14.3300m 1094n -14.1700m
+ 1117n -14.1700m 1118n -14.0100m 1141n -14.0100m 1142n -13.8500m
+ 1165n -13.8500m 1166n -13.6900m 1189n -13.6900m 1190n -13.5300m
+ 1213n -13.5300m 1214n -13.3700m 1237n -13.3700m 1238n -13.2100m
+ 1261n -13.2100m 1262n -13.0500m 1285n -13.0500m 1286n -12.8900m
+ 1309n -12.8900m 1310n -12.7300m 1333n -12.7300m 1334n -12.5700m
+ 1357n -12.5700m 1358n -12.4100m 1381n -12.4100m 1382n -12.2500m
+ 1405n -12.2500m 1406n -12.0900m 1429n -12.0900m 1430n -11.9300m
+ 1453n -11.9300m 1454n -11.7700m 1477n -11.7700m 1478n -11.6100m
+ 1501n -11.6100m 1502n -11.4500m 1525n -11.4500m 1526n -11.2900m
+ 1549n -11.2900m 1550n -11.1300m 1573n -11.1300m 1574n -11.1300m
+ 1597n -11.1300m 1598n -11.1300m
+ )
Eddprobe dd 0 xa.xlayout_dut.aop xa.xlayout_dut.aon 1
Eapo apo 0 xa.xlayout_dut.aop 0 1
.include "design.ngspice"
.include "sources/dut/comparator.dut-layout-mm.spice"
.include "sources/testbench/tb_offset_tran_extracted.spice"
.control
set num_threads=1
.endc
