* comparator-kickback -- GENERATED by sim/tools/mk_klt_request.py, do not edit
* dut=comparator-dr0001 (schematic) sha256=0df618e73b1f0736
* source-sha256 0df618e73b1f0736aac33c786eac58e5a7381f55b3a4e41dc4eb56d9a8ad0d8a sources/dut/comparator.spice
* source-sha256 9ed024b2e635e241570e47b0e48c2fbe8719c0c4dbd38c92b7e97c1b06e49701 sources/dut-binding.json
* source-sha256 b4a30133de89cda6459ec8f2ed2bedadb2ad942c09cf503757ae7e5f58e3a0e1 sources/testbench/tb.json
* source-sha256 f42495917522fa2c726d29ad6ef053284482489c93da3b9bc2236678fea4e090 sources/testbench/tb_kickback.spice
* source-sha256 3a1bd8f03483f1028effeb71342f46e468aa007a4f4902cbc0c0ec25c5bf9632 sources/testbench/tb_vosprobe.spice
.param vdd_nom=3.3
.param vdd_val=3.3
.param temp_c=27.0
.param dut_ib=1e-05
.param dut_vcm=1.65
.param dut_vos=0.0
.include "design.ngspice"
.options reltol=1e-4
.options vntol=1e-9
.options abstol=1e-15
.options chgtol=1e-16
.include "sources/dut/comparator.spice"
.include "sources/testbench/tb_kickback.spice"
