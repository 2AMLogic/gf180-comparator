* comparator-kickback -- GENERATED by sim/tools/mk_klt_request.py, do not edit
* dut=comparator-dr0001 (schematic) sha256=79dcc79fb6a876bc
.param vdd_nom=3.3
.param vdd_val=2.97
.param temp_c=27.0
.param dut_ib=1e-05
.param dut_vcm=1.65
.param dut_vos=0.0
.include "design.ngspice"
.options reltol=1e-4
.options vntol=1e-9
.options abstol=1e-15
.options chgtol=1e-16
.include "/home/ubuntu/GitHub/gf180-comparator/.loom/worktrees/issue-102/design/comparator.spice"
.include "/home/ubuntu/GitHub/gf180-comparator/.loom/worktrees/issue-102/sim/comparator-kickback/testbench/tb_kickback.spice"
