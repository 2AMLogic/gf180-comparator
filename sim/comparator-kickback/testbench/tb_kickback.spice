* tb_kickback -- charge kicked back into the comparator's own input nodes by
* a decision, measured two ways: at the source impedance README.md's kickback
* row is stated at, and against a floating high-impedance source that cannot
* restore the injected charge.
*
* Netlist FRAGMENT. The harness supplies the models, the corner .lib
* sections, .temp, the DUT netlist, the .control block and .end
* (sim/harness/README.md). Parameters from the harness: vdd_val, vdd_nom,
* temp_c, dut_ib, dut_vcm.
*
* METHODOLOGY PORTED FROM gf180-sar-adc/sim/comparator-kickback/ -- see this
* experiment's README.md for the full transfer/non-transfer list.
*
* THE ONE THING THAT MAKES THIS MEASUREMENT REAL: THE SOURCE IMPEDANCE.
* Biasing the inputs from ideal voltage sources restores the injected charge
* instantly and reports ~0 kickback no matter how bad it is; that is the
* standard way this measurement gets faked. Two independent drives are used
* here instead, and BOTH are in the record:
*
*   A -- 1 kohm series source impedance with 100 fF of input-node
*        capacitance. This is the condition README.md's kickback row is
*        stated at ("<= 5 mV disturbance into a 1 kohm source impedance at
*        the input nodes, single decision edge"), so it is what the row is
*        eventually scored against. It reports the PEAK transient
*        disturbance, because at 100 ps of RC the node recovers long before
*        the next decision.
*
*   B/C -- a 1 pF input node fed through 1 Gohm, i.e. RC = 1 ms against a
*        ~30 ns decision cycle: the bias network sets the operating point
*        and then does nothing. This is the sibling repo's floating-node
*        methodology and it reports the RESIDUAL charge left on the node
*        after the decision -- the component that does not recover at all.
*        B sits at a 1 mV residue and C at 100 mV, so their difference is
*        the SIGNAL-DEPENDENT part of the kickback, which is the only part
*        that cannot be absorbed as an offset.
*
* THE RESIDUAL PROBES ARE REFERENCED NEAR ZERO VOLTS, DELIBERATELY. ngspice's
* `meas` returns roughly six significant digits, so differencing two ~1.2 V
* node levels quantizes the answer at ~1 microvolt -- and the residual
* kickback of a well-isolated input stage is smaller than that. The sibling
* repo's own kickback record documents this exact floor, and states that
* buying the extra decades requires measuring a quantity that is ALREADY
* small rather than tightening tolerances. That is what the Bbd/Bcd/Bbc
* behavioural sources below do: they compute the differential (or
* common-mode-referred) node voltage as a signal near 0 V, so `meas` returns
* six digits OF THE SMALL QUANTITY and the floor drops to ~1 nV. Both the
* raw-node-difference and the referenced forms are reported so the
* improvement is visible in the record rather than asserted here.
*
* MISMATCH IS OFF (PDK default sw_stat_mismatch = 0). Kickback and offset are
* separable effects budgeted separately; a mismatched instance would add its
* own offset to the measured input displacement and make neither
* attributable.

.param rsrc=1k
.param cin=100f
.param rfloat=1G
.param cfloat=1p
.param dv_small=1m
.param dv_big=100m
.param t_pre=29n
.param t_post=55n

vsup vdd 0 dc {vdd_val}
vcm  cm 0 dc {dut_vcm}

* One strobe, late enough that every node has settled from the operating
* point before the decision happens.
vclk clk 0 pulse(0 {vdd_val} 30n 100p 100p 10n 30n)

* ---- A: 1 kohm source impedance (README.md's stated condition) --------
vsa  sa 0 dc {dv_small}
Easp asp cm sa 0 0.5
Easn asn cm sa 0 -0.5
Rap  asp apa {rsrc}
Ran  asn ana {rsrc}
Cap  apa 0 {cin}
Can  ana 0 {cin}
iba  vdd ibna dc {dut_ib}
Xa   apa ana clk ibna douta doutba vdd 0 comparator_dut

* ---- B: floating high-Z input, small residue --------------------------
vsb  sb 0 dc {dv_small}
Ebsp bsp cm sb 0 0.5
Ebsn bsn cm sb 0 -0.5
Rbp  bsp bpp {rfloat}
Rbn  bsn bpn {rfloat}
Cbp  bpp 0 {cfloat}
Cbn  bpn 0 {cfloat}
ibb  vdd ibnb dc {dut_ib}
Xb   bpp bpn clk ibnb doutb doutbb vdd 0 comparator_dut

* ---- C: floating high-Z input, large residue --------------------------
vsc  sc 0 dc {dv_big}
Ecsp csp cm sc 0 0.5
Ecsn csn cm sc 0 -0.5
Rcp  csp cpp {rfloat}
Rcn  csn cpn {rfloat}
Ccp  cpp 0 {cfloat}
Ccn  cpn 0 {cfloat}
ibc  vdd ibnc dc {dut_ib}
Xc   cpp cpn clk ibnc doutc doutbc vdd 0 comparator_dut

* ---- near-zero-referenced probes (see header) -------------------------
* ad: instantaneous disturbance of A's + input relative to its own driving
*     source, so the peak is measured against what the node WOULD have been.
Bad ad 0 v = 'v(apa)-v(asp)'
* bd/cd: differential input voltage of the floating instances, a ~1 mV and
*     ~100 mV quantity rather than a ~1.2 V one.
Bbd bd 0 v = 'v(bpp)-v(bpn)'
Bcd cd 0 v = 'v(cpp)-v(cpn)'
* bc: common-mode displacement of the floating instance, referenced to the
*     bias so it too is a small quantity.
Bbc bc 0 v = '(v(bpp)+v(bpn))/2-v(cm)'

* ---- supply-normalized decision probes --------------------------------
Bdan dan 0 v = 'v(douta)/v(vdd)'
Bdbn dbn 0 v = 'v(doutb)/v(vdd)'
Bdcn dcn 0 v = 'v(doutc)/v(vdd)'
