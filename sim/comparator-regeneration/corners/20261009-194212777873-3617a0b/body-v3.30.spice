* comparator-regeneration -- GENERATED by sim/tools/mk_klt_request.py, do not edit
* dut=comparator-dr0001 (schematic) sha256=0df618e73b1f0736
* source-sha256 0df618e73b1f0736aac33c786eac58e5a7381f55b3a4e41dc4eb56d9a8ad0d8a sources/dut/comparator.spice
* source-sha256 9ed024b2e635e241570e47b0e48c2fbe8719c0c4dbd38c92b7e97c1b06e49701 sources/dut-binding.json
* source-sha256 6d0974a016ec444377d11c7037ec5308406c828b3f563eb63a6fdee583958879 sources/testbench/tb.json
* source-sha256 2e257696e3b20bb3f80353650415f3b53379d96e0f514fb243d6d0b6d2c6769c sources/testbench/tb_regeneration.spice
* source-sha256 56475d33709d034f209970fe4cecd0d8095e2b9a0c9aaa078569dadf9674a0d0 sources/testbench/tb_vosprobe.spice
.param vdd_nom=3.3
.param vdd_val=3.3
.param temp_c=27.0
.param dut_ib=1e-05
.param dut_vcm=1.65
.param dut_vos=0.0
.include "design.ngspice"
.options reltol=1e-4
.options vntol=1e-9
.options abstol=1e-13
.include "sources/dut/comparator.spice"
.include "sources/testbench/tb_regeneration.spice"
